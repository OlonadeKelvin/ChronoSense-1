* ChronoSense-1  --  analog core, transistor level
* IHP SG13CMOS5L, VDD = 1.2 V nominal (1.08 - 1.32)

.lib "$PDKPATH/libs.tech/ngspice/models/cornerMOSlv.lib" mos_tt
.param VDD=1.2 VREF=0.6 CT=15p
Vdd  vdd  0 {VDD}
Vss  vss  0 0
Vref vref 0 {VREF}

* sense resistor
Rext pad 0 10k

* V-to-I converter

XOTA  vg pad vref vdd vss ota
Cc    vg vss 2p
XMPASS pad vg vdd vdd sg13_lv_pmos w=5u l=1u m=20
XMMIR  ctn vg vdd vdd sg13_lv_pmos w=5u l=1u m=30

* Integrator + comparator + reset   (FROZEN)

CT    ctn vss {CT}
XMRST ctn sch vss vss sg13_lv_nmos w=10u l=0.35u
XSCH  sch ctn vdd vss schmitt
XINV1 schb sch  vdd vss inv
XINV2 out  schb vdd vss inv

* Subcircuits
* 5T OTA
.subckt ota vout vin vip vdd vss
XM1  vx    vin vtail vss sg13_lv_nmos w=5u l=0.5u m=4
XM2  vout  vip vtail vss sg13_lv_nmos w=5u l=0.5u m=4
XM3  vx    vx  vdd   vdd sg13_lv_pmos w=5u l=1u   m=2
XM4  vout  vx  vdd   vdd sg13_lv_pmos w=5u l=1u   m=2
XM5  vtail vb  vss   vss sg13_lv_nmos w=5u l=1u   m=2
XMB  vb    vb  vss   vss sg13_lv_nmos w=5u l=1u   m=2
RB   vdd   vb  30k
.ends

*6T Schmitt + output buffer
.subckt schmitt out in vdd vss
XMN1 x    in   vss vss sg13_lv_nmos w=3u l=0.35u
XMN2 outi in   x   vss sg13_lv_nmos w=3u l=0.35u
XMN3 vdd  outi x   vss sg13_lv_nmos w=3u l=0.35u
XMP1 y    in   vdd vdd sg13_lv_pmos w=6u l=0.35u
XMP2 outi in   y   vdd sg13_lv_pmos w=6u l=0.35u
XMP3 vss  outi y   vdd sg13_lv_pmos w=6u l=0.35u
XBUF out  outi vdd vss inv
.ends

.subckt inv out in vdd vss
XP out in vdd vdd sg13_lv_pmos w=2u l=0.35u
XN out in vss vss sg13_lv_nmos w=1u l=0.35u
.ends

.subckt tgate a b sel selb vdd vss
XMN a sel  b vss sg13_lv_nmos w=5u l=0.35u m=4
XMP a selb b vdd sg13_lv_pmos w=5u l=0.35u m=8
.ends

* Simulation control
.ic v(ctn)=0.5
.options method=gear reltol=1e-4 itl4=100
.tran 50p 3u
.control
run
meas tran t20  TRIG v(out) VAL=0.6 RISE=5 TARG v(out) VAL=0.6 RISE=25
meas tran vmax MAX v(ctn) FROM=2u   TO=2.5u
meas tran vmin MIN v(ctn) FROM=2u   TO=2.5u
meas tran vpad AVG v(pad) FROM=2u   TO=2.5u
let tper = t20/20
print tper vmax vmin vpad
quit
.endc
.end
