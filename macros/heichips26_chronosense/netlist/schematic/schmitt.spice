** sch_path: /foss/designs/Hei_Chips/ChronoSense-1/macros/heichips26_chronosense/schematic/xschem/schmitt.sch
.subckt schmitt vdd out vss in
*.PININFO in:I vdd:B vss:B out:O
MM1 net2 in vss vss sg13_lv_nmos w=3u l=0.35u ng=1
MM2 net1 in vdd vdd sg13_lv_pmos w=6u l=0.35u ng=1
MM3 net3 in net2 vss sg13_lv_nmos w=3u l=0.35u ng=1
MM4 net2 net3 vdd vss sg13_lv_nmos w=3u l=0.35u ng=1
MM5 net3 in net1 vdd sg13_lv_pmos w=6u l=0.35u ng=1
MM6 net1 net3 vss vdd sg13_lv_pmos w=6u l=0.35u ng=1
x3 vdd net3 out vss inv
.ends

* expanding   symbol:  /foss/designs/Hei_Chips/ChronoSense-1/macros/heichips26_chronosense/schematic/xschem/inv.sym # of pins=4
** sym_path: /foss/designs/Hei_Chips/ChronoSense-1/macros/heichips26_chronosense/schematic/xschem/inv.sym
** sch_path: /foss/designs/Hei_Chips/ChronoSense-1/macros/heichips26_chronosense/schematic/xschem/inv.sch
.subckt inv VDD IN OUT VSS
*.PININFO IN:I OUT:O VDD:B VSS:B
MM1 OUT IN VDD VDD sg13_lv_pmos w=2u l=0.35u ng=1
MM2 OUT IN VSS VSS sg13_lv_nmos w=1u l=0.35u ng=1
.ends
