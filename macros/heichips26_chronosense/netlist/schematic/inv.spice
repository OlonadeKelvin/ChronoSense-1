** sch_path: /foss/designs/Hei_Chips/ChronoSense-1/macros/heichips26_chronosense/schematic/xschem/inv.sch
.subckt inv VDD IN OUT VSS
*.PININFO IN:I OUT:O VDD:B VSS:B
MM1 OUT IN VDD net1 sg13_lv_pmos w=2u l=0.35u ng=1
MM2 OUT IN VSS net2 sg13_lv_nmos w=1u l=0.35u ng=1
RR1 VDD net1 ntap1 A=1.2168e-12 P=4.68e-06
RR2 VSS net2 ptap1 A=1.2168e-12 P=4.68e-06
.ends
